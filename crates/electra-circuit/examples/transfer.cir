* DC gain of a 1 kohm / 2 kohm divider is 2/3.
.dc Vin 0 3 500m
Vin in 0 9
R1 in out 1k
R2 out 0 2k
.end
