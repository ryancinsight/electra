.include ../crates/electra-circuit/examples/hierarchical-divider.cir
