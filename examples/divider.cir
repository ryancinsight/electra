.include ../crates/electra-circuit/examples/divider.cir
