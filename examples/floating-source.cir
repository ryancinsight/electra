.include ../crates/electra-circuit/examples/floating-source.cir
