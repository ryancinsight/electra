.include ../crates/electra-circuit/examples/rail.cir
