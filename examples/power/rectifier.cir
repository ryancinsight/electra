Electra rectifier startup qualification
Vs src 0 SIN(0 2 1000)
D1 src out ideal
.model ideal D(IS=1e-12 N=1 TNOM=27)
R1 out 0 100
C1 out 0 10u IC=0
.temp 27
.options reltol=1e-8 abstol=1e-14
.tran 0.1u 0.01 0 0.1u UIC
.control
run
meas tran mean_v AVG v(out) from=0.009 to=0.01
meas tran ripple_v PP v(out) from=0.009 to=0.01
quit
.endc
.end
