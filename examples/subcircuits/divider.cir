.include ../../crates/electra-circuit/examples/subcircuits/divider.cir
