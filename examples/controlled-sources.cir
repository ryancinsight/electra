.include ../crates/electra-circuit/examples/controlled-sources.cir
