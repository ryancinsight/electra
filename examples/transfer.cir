.include ../crates/electra-circuit/examples/transfer.cir
