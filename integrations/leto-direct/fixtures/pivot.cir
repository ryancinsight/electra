Vleft a mid -5
Vright b mid 2
Rleft 0 a 4
Rright 0 b 8
Rmid mid a 128
Rtap tap a 128
